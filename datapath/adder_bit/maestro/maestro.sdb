ADE simulation setup
Run mode: Single Run, Sweeps and Corners
Tests:
  mp_datapath_adder_bit_1: mp_datapath/adder_bit/schematic, simulator spectre
