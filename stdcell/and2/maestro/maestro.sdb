ADE simulation setup
Run mode: Single Run, Sweeps and Corners
Tests:
  mp_stdcell_and2_1: mp_stdcell/and2/schematic, simulator spectre
