ADE simulation setup
Run mode: Single Run, Sweeps and Corners
Tests:
  mp_stdcell_oai21_1: mp_stdcell/oai21/schematic, simulator spectre
