ADE simulation setup
Run mode: Single Run, Sweeps and Corners
Tests:
  mp_intro_buf_1: mp_intro/buf/schematic, simulator spectre
