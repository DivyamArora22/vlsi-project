ADE simulation setup
Run mode: Single Run, Sweeps and Corners
Tests:
  mp_stdcell_nor2_1: mp_stdcell/nor2/schematic, simulator spectre
