ADE simulation setup
Test mp_intro_inv_1: mp_intro/inv/schematic, simulator spectre
  Models: /class/ece425/FreePDK45/ncsu_basekit/models/hspice/hspice_nom.include
  Temperature: 27
  Stimulus vdd!: voltage dc dc=1 srcType=dc
  Stimulus vss!: voltage dc dc=0 srcType=dc
  Stimulus A: voltage bit val1=1 val0=0 delay=0 rise=10p fall=10p period=2.5n srcType=bit data=0101
  Analysis tran: stop=10n
  Signals: /A, /Y
Run mode: Single Run, Sweeps and Corners
