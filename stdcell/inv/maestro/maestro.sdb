ADE simulation setup
Run mode: Single Run, Sweeps and Corners
Tests:
  mp_intro_inv_1: mp_intro/inv/schematic, simulator spectre
