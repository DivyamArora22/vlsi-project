ADE simulation setup
Run mode: Single Run, Sweeps and Corners
Tests:
  mp_stdcell_mux2_1: mp_stdcell/mux2/schematic, simulator spectre
