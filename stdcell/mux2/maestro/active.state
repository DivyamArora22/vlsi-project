ADE simulation setup
Test mp_stdcell_mux2_1: mp_stdcell/mux2/schematic, simulator spectre
  Models: /class/ece425/FreePDK45/ncsu_basekit/models/hspice/hspice_nom.include
  Temperature: 27
  Stimulus vdd!: voltage dc dc=1 srcType=dc
  Stimulus vss!: voltage dc dc=0 srcType=dc
  Stimulus S: voltage bit val1=1 val0=0 delay=0 rise=10p fall=10p period=2.5n srcType=bit data=00001111
  Stimulus D0: voltage bit val1=1 val0=0 delay=0 rise=10p fall=10p period=2.5n srcType=bit data=00110011
  Stimulus D1: voltage bit val1=1 val0=0 delay=0 rise=10p fall=10p period=2.5n srcType=bit data=01010101
  Analysis tran: stop=20n
  Signals: /S, /D0, /D1, /Y
Run mode: Single Run, Sweeps and Corners
