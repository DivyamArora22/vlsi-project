ADE simulation setup
Run mode: Single Run, Sweeps and Corners
Tests:
  mp_stdcell_or2_1: mp_stdcell/or2/schematic, simulator spectre
