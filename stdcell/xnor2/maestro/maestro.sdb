ADE simulation setup
Run mode: Single Run, Sweeps and Corners
Tests:
  mp_stdcell_xnor2_1: mp_stdcell/xnor2/schematic, simulator spectre
