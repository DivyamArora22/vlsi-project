ADE simulation setup
Run mode: Single Run, Sweeps and Corners
Tests:
  mp_stdcell_aoi21_1: mp_stdcell/aoi21/schematic, simulator spectre
