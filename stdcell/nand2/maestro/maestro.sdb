ADE simulation setup
Run mode: Single Run, Sweeps and Corners
Tests:
  mp_stdcell_nand2_1: mp_stdcell/nand2/schematic, simulator spectre
