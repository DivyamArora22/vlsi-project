ADE simulation setup
Run mode: Single Run, Sweeps and Corners
Tests:
  mp_stdcell_latch_1: mp_stdcell/latch/schematic, simulator spectre
