ADE simulation setup
Test mp_stdcell_latch_1: mp_stdcell/latch/schematic, simulator spectre
  Models: /class/ece425/FreePDK45/ncsu_basekit/models/hspice/hspice_nom.include
  Temperature: 27
  Stimulus vss!: voltage dc dc=0 srcType=dc
  Stimulus vdd!: voltage dc dc=1 srcType=dc
  Stimulus D: voltage bit val1=1 val0=0 delay=0 rise=10p fall=10p period=1.5n srcType=bit data=0010001110
  Stimulus EN: voltage bit val1=1 val0=0 delay=0 rise=10p fall=10p period=2n srcType=bit data=01010101
  Analysis tran: stop=15n
  Signals: /D, /EN, /Q
Run mode: Single Run, Sweeps and Corners
