ADE simulation setup
Run mode: Single Run, Sweeps and Corners
Tests:
  mp_stdcell_dff_1: mp_stdcell/dff/schematic, simulator spectre
