ADE simulation setup
Test mp_stdcell_dff_1: mp_stdcell/dff/schematic, simulator spectre
  Models: /class/ece425/FreePDK45/ncsu_basekit/models/hspice/hspice_nom.include
  Temperature: 27
  Stimulus vdd!: voltage dc dc=1 srcType=dc
  Stimulus vss!: voltage dc dc=0 srcType=dc
  Stimulus D: voltage bit val1=1 val0=0 delay=0 rise=10p fall=10p period=2.5n srcType=bit data=0011
  Stimulus CLK: voltage bit val1=1 val0=0 delay=0 rise=10p fall=10p period=2.5n srcType=bit data=0101
  Analysis tran: stop=10n
  Signals: /D, /CLK, /Q
Run mode: Single Run, Sweeps and Corners
